* 7330744 Variant 6 - Photo Relay - GUI import schematic for NI Multisim 14.3
* Standard SPICE equivalents are used so Multisim can generate a graphical schematic.

VCTRL U_CTRL COM DC 12
R1 U_CTRL N_R1 4.7MEG
R2 N_R1 SENS 47K
D_VD1 COM SENS DPHOTO
C1 SENS COM 0.47u
C2 U_CTRL COM 0.1u
D_VD2 COM U_CTRL DZ12

M_VT1 SENS G12 T1 COM NLOGIC
M_VT2 T1 G12 T2 COM NLOGIC
R3 G12 COM 330
R4 U_CTRL T1 10K
R5 U_CTRL T2 5.1K

M_VT3 DRV COM T2 COM NPOWER
R6 DRV DRV2 51

R7 L N_R7 58K
D_VD3 N_R7 N_LED DGEN
D_HL1 N_LED U_CTRL DLEDRED

R_FU1 DRV2 BR_A 0.01
D_BR1 BR_A G1 DBR
D_BR2 COM G1 DBR
D_BR3 BR_A G2 DBR
D_BR4 COM G2 DBR

R8 G1 COM 56
D_VD4 COM G1 DGEN
R9 G2 SW 56
D_VD5 SW G2 DGEN

S_VS1 SW COM G1 COM SWTH
S_VS2 COM SW G2 COM SWTH

D_RU1A DRV2 MOVX DZ390
D_RU1B COM MOVX DZ390
C3 L COM 47n

VMAINS L N SIN(0 311 50)
R_FU2 N COM 0.01
RLOAD L SW 1K

.MODEL DPHOTO D(IS=2n RS=20 N=1.4 BV=30 IBV=1u CJO=20p)
.MODEL DZ12 D(IS=5n RS=2 N=1.5 BV=12 IBV=1m)
.MODEL DZ390 D(IS=5n RS=2 N=1.5 BV=390 IBV=1m)
.MODEL DGEN D(IS=10n RS=0.6 N=1.9 BV=400 IBV=10u CJO=10p)
.MODEL DBR D(IS=5n RS=0.5 N=1.8 BV=600 IBV=5u CJO=20p)
.MODEL DLEDRED D(IS=1n RS=10 N=2 EG=1.8)
.MODEL NLOGIC NMOS(VTO=2.5 KP=20m LAMBDA=0.02 RD=1 RS=1 CGS=20p CGD=10p)
.MODEL NPOWER NMOS(VTO=3.5 KP=2 LAMBDA=0.01 RD=0.05 RS=0.05 CGS=500p CGD=150p)
.MODEL SWTH SW(RON=0.05 ROFF=1G VON=4 VOFF=2)

.END
