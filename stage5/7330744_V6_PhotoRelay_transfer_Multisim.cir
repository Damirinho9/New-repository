* 7330744 Variant 6 - Photo Relay - DC transfer characteristic
* Sweeps equivalent photodiode current from darkness to bright light.

VCTRL VDD 0 DC 12
I_PHOTO SENS 0 DC 0
D_PHOTO 0 SENS DPHOTO
R_SENS VDD SENS 1MEG

VDRIVE DRVSRC 0 DC 10
S_CTRL DRVSRC GDRV SENS 0 SWCTRL
R_GDRV GDRV 0 10k

R_LED GDRV LEDA 2.2k
D_LED LEDA 0 DLEDRED

.MODEL DPHOTO D(IS=2n RS=20 N=1.4 BV=30 IBV=1u CJO=20p)
.MODEL DLEDRED D(IS=1n RS=10 N=2 EG=1.8)
.MODEL SWCTRL SW(RON=1 ROFF=1G VON=5.0 VOFF=4.8)

.DC I_PHOTO 0 12u 0.1u
.PROBE V(SENS) V(GDRV)
.END
