* 7330744 Variant 6 - Photo Relay - Functional Multisim SPICE model v2
* Demonstrates: illumination -> photodiode current -> RC/control stage -> anti-parallel SCR stage -> load
* Original documentation parts remain in the report; simulation uses stable functional equivalents.

* --- Control supply ---
VCTRL VDD 0 DC 12

* --- Photodiode FD320 functional equivalent ---
* Bright light = 10 uA (0-4 s), near threshold = 6 uA (4-8 s), dark = 1 uA (8-12 s)
I_PHOTO SENS 0 PWL(0 10u 3.999 10u 4.000 6u 7.999 6u 8.000 1u 12 1u)
D_PHOTO 0 SENS DPHOTO
R_SENS VDD SENS 1MEG
C_SENS SENS 0 1u

* --- Functional equivalent of transistor control cascade VT1-VT3 ---
* SENS below threshold => GDRV=0; SENS above threshold => GDRV about 10 V.
VDRIVE DRVSRC 0 DC 10
S_CTRL DRVSRC GDRV SENS 0 SWCTRL
R_GDRV GDRV 0 10k
C_GDRV GDRV 0 10n

* Status LED equivalent
R_LED GDRV LEDA 2.2k
D_LED LEDA 0 DLEDRED

* --- 220 V / 50 Hz power path and test load ---
VLINE L 0 SIN(0 311 50)
RLOAD L LOAD 1k

* Functional equivalents of two anti-parallel T123-250 thyristors.
* Each branch is a controlled ideal contact plus a directional power diode.
S_VS1 LOAD XVS1 GDRV 0 SWPWR
D_VS1 XVS1 0 DPOWER
S_VS2 0 XVS2 GDRV 0 SWPWR
D_VS2 XVS2 LOAD DPOWER

* Snubber / protection functional equivalents
C_SNUB LOAD 0 47n
R_SNUB LOAD SNUB 100
C_SNUB2 SNUB 0 47n

.MODEL DPHOTO D(IS=2n RS=20 N=1.4 BV=30 IBV=1u CJO=20p)
.MODEL DLEDRED D(IS=1n RS=10 N=2 EG=1.8)
.MODEL DPOWER D(IS=100n RS=0.03 N=1.5 BV=800 IBV=50u CJO=200p)
.MODEL SWCTRL SW(RON=1 ROFF=1G VON=5.0 VOFF=4.8)
.MODEL SWPWR SW(RON=0.05 ROFF=1G VON=5.0 VOFF=4.0)

.TRAN 0.1m 12
.PROBE V(SENS) V(GDRV) V(L) V(LOAD) I(RLOAD)
.END
