* 7330744 Variant 6 - Photo Relay - editable schematic source for multisim-mcp
* Common bus is node 0 for native Multisim ground placement.

VCTRL U_CTRL 0 DC 12
R1 U_CTRL N_R1 4.7MEG
R2 N_R1 SENS 47K
D_VD1 0 SENS DPHOTO
C1 SENS 0 0.47u
C2 U_CTRL 0 0.1u
D_VD2 0 U_CTRL DZ12

M_VT1 SENS G12 T1 0 NLOGIC
M_VT2 T1 G12 T2 0 NLOGIC
R3 G12 0 330
R4 U_CTRL T1 10K
R5 U_CTRL T2 5.1K

M_VT3 DRV 0 T2 0 NPOWER
R6 DRV DRV2 51

R7 L N_R7 58K
D_VD3 N_R7 N_LED DGEN
D_HL1 N_LED U_CTRL DLEDRED

R_FU1 DRV2 BR_A 0.01
D_BR1 BR_A G1 DBR
D_BR2 0 G1 DBR
D_BR3 BR_A G2 DBR
D_BR4 0 G2 DBR

R8 G1 0 56
D_VD4 0 G1 DGEN
R9 G2 SW 56
D_VD5 SW G2 DGEN

S_VS1 SW 0 G1 0 SWTH
S_VS2 0 SW G2 0 SWTH

* RU1 FNR-20K391: open-state schematic placeholder; nonlinear MOV remains in simulation model
R_RU1 DRV2 0 1G
C3 L 0 47n

VMAINS L N SIN(0 311 50)
R_FU2 N 0 0.01
RLOAD L SW 1K

.MODEL DPHOTO D(IS=2n RS=20 N=1.4 BV=30 IBV=1u CJO=20p)
.MODEL DZ12 D(IS=5n RS=2 N=1.5 BV=12 IBV=1m)
.MODEL DGEN D(IS=10n RS=0.6 N=1.9 BV=400 IBV=10u CJO=10p)
.MODEL DBR D(IS=5n RS=0.5 N=1.8 BV=600 IBV=5u CJO=20p)
.MODEL DLEDRED D(IS=1n RS=10 N=2 EG=1.8)
.MODEL NLOGIC NMOS(VTO=2.5 KP=20m LAMBDA=0.02 RD=1 RS=1 CGS=20p CGD=10p)
.MODEL NPOWER NMOS(VTO=3.5 KP=2 LAMBDA=0.01 RD=0.05 RS=0.05 CGS=500p CGD=150p)
.MODEL SWTH SW(RON=0.05 ROFF=1G VON=4 VOFF=2)

.END
